* RC Low-Pass Filter - AC and Transient Analysis
* Shows frequency response and step response of a 1st-order RC filter
* Cutoff frequency: f_c = 1/(2*pi*R*C) = ~1.59 kHz
*
* Tool: NGspice

* --- Netlist ---
* Input source: 1V AC, 1kHz sine for transient
Vin in 0 DC 0 AC 1 SIN(0 1 1k)

* Components
R1 in out 1k
C1 out 0 100n

* --- Analysis ---
.control
  * AC sweep: 10 Hz to 10 MHz, 100 points per decade
  ac dec 100 10 10Meg

  * Plot magnitude (Bode plot)
  set hcopydevtype=svg
  set hcopypscolor=1
  plot vdb(out) title 'RC Low-Pass Filter Magnitude Response'
  plot cph(v(out))*180/PI title 'RC Low-Pass Filter Phase Response'

  * Transient analysis: 5ms, step 1us
  tran 1u 5m

  plot v(in) v(out) title 'RC Low-Pass Filter Transient Response'
.endc

.end
